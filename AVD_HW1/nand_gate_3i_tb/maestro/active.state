ADE simulation setup
Test Project_nand_gate_3i_tb_1: AVD_HW1/nand_gate_3i_tb/schematic, simulator spectre
  Models: /package/eda/cadence/gpdk045/gpdk045_v_6_0/gpdk045/../models/spectre/gpdk045.scs[tt]
  Variables: wp = 175n
  Temperature: 27
  Stimulus vdd!: voltage dc dc=1.1
  Stimulus A: voltage dc dc=1.1
  Stimulus B: voltage dc dc=1.1
  Stimulus C: voltage pulse dc=1.1 val0=0 val1=1.1 period=4n delay=0 rise=30p fall=30p width=2n
  Analysis tran: stop=10n
  Output tphl_C_rises_Out_falls = delay(?wf1 VT("/C") ?value1 0.55 ?edge1 "rising" ?nth1 1 ?td1 0.0 ?tol1 nil ?wf2 VT("/Out") ?value2 0.55 ?edge2 "falling" ?nth2 1 ?tol2 nil ?td2 nil ?stop nil ?multiple nil)
  Output tplh_C_falls_Out_rises = delay(?wf1 VT("/C") ?value1 0.55 ?edge1 "falling" ?nth1 1 ?td1 0.0 ?tol1 nil ?wf2 VT("/Out") ?value2 0.55 ?edge2 "rising" ?nth2 1 ?tol2 nil ?td2 nil ?stop nil ?multiple nil)
  Signals: /A, /B, /C, /Out
Run mode: Single Run, Sweeps and Corners
