ADE simulation setup
Run mode: Single Run, Sweeps and Corners
Tests:
  Project_nand_gate_2i_tb_1: AVD_HW1/nand_gate_2i_tb/schematic, simulator spectre
