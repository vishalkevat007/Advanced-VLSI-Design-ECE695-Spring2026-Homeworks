ADE simulation setup
Test AVD_HW1_mux_2_1_tb_1: AVD_HW1/mux_2_1_tb/schematic, simulator spectre
  Models: /package/eda/cadence/gpdk045/gpdk045_v_6_0/gpdk045/../models/spectre/gpdk045.scs[tt]
  Temperature: 27
  Stimulus vdd!: voltage dc dc=1.1 srcType=dc
  Stimulus A: voltage bit val1=1.1 val0=0 rise=30p fall=30p period=2n srcType=bit data=101
  Stimulus B: voltage bit val1=1.1 val0=0 rise=30p fall=30p period=2n srcType=bit data=010
  Stimulus S: voltage dc dc=0 srcType=dc
  Stimulus S_b: voltage dc dc=1.1 srcType=dc
  Analysis tran: stop=6n
  Output A_fall_Out_rise = delay(?wf1 VT("/A") ?value1 0.55 ?edge1 "falling" ?nth1 1 ?td1 0.0 ?tol1 nil ?wf2 VT("/Out") ?value2 0.55 ?edge2 "rising" ?nth2 1 ?tol2 nil ?td2 nil ?stop nil ?multiple nil)
  Output B_rise_Out_fall = delay(?wf1 VT("/B") ?value1 0.55 ?edge1 "rising" ?nth1 1 ?td1 0.0 ?tol1 nil ?wf2 VT("/Out") ?value2 0.55 ?edge2 "falling" ?nth2 1 ?tol2 nil ?td2 nil ?stop nil ?multiple nil)
  Signals: /A, /B, /Out, /I0/net2
Run mode: Single Run, Sweeps and Corners
