ADE simulation setup
Test AVD_HW2_ring_oscilator_13_tb_1: AVD_HW2/ring_oscilator_13_tb/schematic, simulator spectre
  Models: /package/eda/cadence/gpdk045/gpdk045_v_6_0/gpdk045/../models/spectre/gpdk045.scs[tt]
  Variables: VDD = 1.1
  Temperature: 27
  Stimulus VddMain: voltage dc dc=VDD srcType=dc
  Stimulus Vdd: voltage dc dc=VDD srcType=dc
  Stimulus EN: voltage dc dc=VDD srcType=dc
  Initial conditions: /I0/n<12> = 0
  Analysis tran: stop=2n
  Output Iavg = average(IT("/I0/VddMain"))
  Output Power = (VAR("VDD") * average(IT("/I0/VddMain")))
  Output timeperiod = delay(?wf1 VT("/I0/n<2>") ?value1 (0.5 * VAR("VDD")) ?edge1 "rising" ?nth1 2 ?td1 0.0 ?tol1 nil ?wf2 VT("/I0/n<2>") ?value2 (0.5 * VAR("VDD")) ?edge2 "rising" ?nth2 3 ?tol2 nil ?td2 nil ?stop nil ?multiple nil)
  Output frequency = (1 / timeperiod)
  Output n1_n2_tphl = delay(?wf1 VT("/I0/n<1>") ?value1 (0.5 * VAR("VDD")) ?edge1 "rising" ?nth1 1 ?td1 0.0 ?tol1 nil ?wf2 VT("/I0/n<2>") ?value2 (0.5 * VAR("VDD")) ?edge2 "falling" ?nth2 1 ?tol2 nil ?td2 nil ?stop nil ?multiple nil)
  Signals: /I0/VddMain (terminal) as I_VddMain, /I0/n<0:12> as n1_n2, /I0/n<2>
Run mode: Single Run, Sweeps and Corners
