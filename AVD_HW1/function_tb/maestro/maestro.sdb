ADE simulation setup
Run mode: Single Run, Sweeps and Corners
Tests:
  AVD_HW1_function_tb_1: AVD_HW1/function_tb/schematic, simulator spectre
