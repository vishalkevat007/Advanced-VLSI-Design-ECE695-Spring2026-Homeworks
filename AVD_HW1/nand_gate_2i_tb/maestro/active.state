ADE simulation setup
Test Project_nand_gate_2i_tb_1: AVD_HW1/nand_gate_2i_tb/schematic, simulator spectre
  Models: /package/eda/cadence/gpdk045/gpdk045_v_6_0/gpdk045/../models/spectre/gpdk045.scs[tt]
  Temperature: 27
  Stimulus vdd!: voltage dc dc=1.1 srcType=dc
  Stimulus A: voltage dc dc=1.1 srcType=dc
  Stimulus B: voltage pulse dc=1.1 val0=0 val1=1.1 period=4n delay=500.0p rise=30p fall=30p width=2n srcType=pulse
  Analysis tran: stop=10n
  Output tphl_B_rises_Out_falls = delay(?wf1 VT("/B") ?value1 0.55 ?edge1 "rising" ?nth1 1 ?td1 0.0 ?tol1 nil ?wf2 VT("/Out") ?value2 0.55 ?edge2 "falling" ?nth2 1 ?tol2 nil ?td2 nil ?stop nil ?multiple nil)
  Output tplh_B_falls_Out_rises = delay(?wf1 VT("/B") ?value1 0.55 ?edge1 "falling" ?nth1 1 ?td1 0.0 ?tol1 nil ?wf2 VT("/Out") ?value2 0.55 ?edge2 "rising" ?nth2 1 ?tol2 nil ?td2 nil ?stop nil ?multiple nil)
  Signals: /A as f, /B, /Out
Run mode: Single Run, Sweeps and Corners
