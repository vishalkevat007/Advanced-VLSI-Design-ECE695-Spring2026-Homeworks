ADE simulation setup
Run mode: Single Run, Sweeps and Corners
Tests:
  Project_nand_gate_2i_tb_1: AVD_HW2/nand_gate_2i_tb/schematic, simulator spectre
    Outputs: tphl_A_rises_Out_falls; tplh_A_falls_Out_rises
