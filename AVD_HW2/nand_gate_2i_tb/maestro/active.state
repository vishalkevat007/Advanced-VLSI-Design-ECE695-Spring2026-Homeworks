ADE simulation setup
Test Project_nand_gate_2i_tb_1: AVD_HW2/nand_gate_2i_tb/schematic, simulator spectre
  Models: /package/eda/cadence/gpdk045/gpdk045_v_6_0/gpdk045/../models/spectre/gpdk045.scs[tt]
  Temperature: 27
  Stimulus vdd!: voltage dc dc=1.1 srcType=dc
  Stimulus A: voltage pulse dc=1.1 val0=0 val1=1.1 period=2n rise=30p fall=30p width=1n srcType=pulse
  Stimulus B: voltage dc dc=1.1 srcType=dc
  Analysis tran: stop=10n
  Output tphl_A_rises_Out_falls = delay(?wf1 VT("/A") ?value1 0.55 ?edge1 "rising" ?nth1 1 ?td1 0.0 ?tol1 nil ?wf2 VT("/Out") ?value2 0.55 ?edge2 "falling" ?nth2 1 ?tol2 nil ?td2 nil ?stop nil ?multiple nil)
  Output tplh_A_falls_Out_rises = delay(?wf1 VT("/A") ?value1 0.55 ?edge1 "falling" ?nth1 1 ?td1 0.0 ?tol1 nil ?wf2 VT("/Out") ?value2 0.55 ?edge2 "rising" ?nth2 1 ?tol2 nil ?td2 nil ?stop nil ?multiple nil)
  Output rise_time = riseTime(VT("/Out") 0 nil 1.1 nil 10 90 nil "time")
  Output fall_time = fallTime(VT("/Out") 1.1 nil 0 nil 10 90 nil "time")
  Signals: /A as A_Input, /B as B_input, /Out as Output
Run mode: Single Run, Sweeps and Corners
