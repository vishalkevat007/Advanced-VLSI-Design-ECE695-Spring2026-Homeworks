ADE simulation setup
Test AVD_HW2_ring_oscilator_13_tb_1: AVD_HW2/ring_oscilator_13_tb/schematic, simulator spectre
  Models: /package/eda/cadence/gpdk045/gpdk045_v_6_0/gpdk045/../models/spectre/gpdk045.scs[tt]
  Variables: VDD = 0.5
  Temperature: 27
  Stimulus VddMain: voltage dc dc=VDD srcType=dc
  Stimulus Vdd: voltage dc dc=VDD srcType=dc
  Stimulus EN: voltage dc dc=1.1 srcType=dc
  Initial conditions: /I0/n<12> = 0
  Analysis tran: stop=100n
  Output Iavg = IDC("/I0/VddMain") (unticked)
  Output Vavg = VDC("/VddMain") (unticked)
  Output Power = (VDC("/VddMain") * IDC("/I0/VddMain")) (unticked)
  Output timeperiod = delay(?wf1 VT("/I0/n<0>") ?value1 (0.5 * VAR("VDD")) ?edge1 "rising" ?nth1 1 ?td1 0.0 ?tol1 nil ?wf2 VT("/I0/n<0>") ?value2 (0.5 * VAR("VDD")) ?edge2 "rising" ?nth2 2 ?tol2 nil ?td2 nil ?stop nil ?multiple nil)
  Output frequency = (1 / timeperiod)
  Output n1_n2_tphl = delay(?wf1 VT("/I0/n<1>") ?value1 (0.5 * VAR("VDD")) ?edge1 "rising" ?nth1 1 ?td1 0.0 ?tol1 nil ?wf2 VT("/I0/n<2>") ?value2 (0.5 * VAR("VDD")) ?edge2 "falling" ?nth2 1 ?tol2 nil ?td2 nil ?stop nil ?multiple nil)
  Signals: /I0/VddMain (terminal), /VddMain, /I0/n<1:2> as n1_n2, /I0/n<0> as n0, /I0/n<1>
Run mode: Single Run, Sweeps and Corners
Setup values for test AVD_HW2_ring_oscilator_13_tb_1: VDD = 1.1
