ADE simulation setup
Test Project_transmission_gate_tb_1: Project/transmission_gate_tb/schematic, simulator spectre
  Models: /package/eda/cadence/gpdk045/gpdk045_v_6_0/gpdk045/../models/spectre/gpdk045.scs[tt]
  Temperature: 27
  Stimulus X: voltage dc dc=1.1 srcType=dc
  Stimulus In: voltage pulse dc=1.1 val0=0 val1=1.1 period=2n rise=30p fall=30p width=1n srcType=pulse
  Stimulus Vdd: voltage dc dc=1.1 srcType=dc
  Stimulus Gnd: voltage dc dc=0 srcType=dc
  Analysis tran: stop=6n
  Output delay(?wf1 VT("/In") ?value1 0.55 ?edge1 "rising" ?nth1 1 ?td1 0.0 ?tol1 nil ?wf2 VT("/Out") ?value2 0.55 ?edge2 "rising" ?nth2 1 ?tol2 nil ?td2 nil ?stop nil ?multiple nil)
  Output delay(?wf1 VT("/In") ?value1 0.55 ?edge1 "falling" ?nth1 1 ?td1 0.0 ?tol1 nil ?wf2 VT("/Out") ?value2 0.55 ?edge2 "falling" ?nth2 1 ?tol2 nil ?td2 nil ?stop nil ?multiple nil)
  Signals: /In, /X, /Out
Run mode: Single Run, Sweeps and Corners
