ADE simulation setup
Run mode: Single Run, Sweeps and Corners
Tests:
  AVD_HW1_mux_2_1_tb_1: AVD_HW1/mux_2_1_tb/schematic, simulator spectre
    Outputs: delay(?wf1 VT("/B") ?value1 0.55 ?edge1 "rising" ?nth1 1 ?td1 0.0 ?tol1 nil ?wf2 VT("/Out") ?value2 0.55 ?edge2 "falling" ?nth2 1 ?tol2 nil ?td2 nil ?stop nil ?multiple nil); A_fall_Out_rise; B_rise_Out_fall
