ADE simulation setup
Run mode: Single Run, Sweeps and Corners
Tests:
  AVD_HW3_clock_gater_std_tb_1: AVD_HW3/clock_gater_std_tb/schematic, simulator spectre
