ADE simulation setup
Test AVD_HW1_function_tb_1: AVD_HW1/function_shanon_wrt_A_tb/schematic, simulator spectre
  Models: /package/eda/cadence/gpdk045/gpdk045_v_6_0/gpdk045/../models/spectre/gpdk045.scs[tt]
  Temperature: 27
  Stimulus vdd!: voltage dc dc=1.1 srcType=dc
  Stimulus A: voltage dc dc=1.1 srcType=dc
  Stimulus B: voltage dc dc=1.1 srcType=dc
  Stimulus C: voltage dc dc=1.1 srcType=dc
  Stimulus D: voltage dc dc=1.1 srcType=dc
  Analysis tran: stop=16n
  Analysis dc
  Output IDC("/I0/Vdd")
  Signals: /A, /B, /C, /D, /F, /I0/Vdd (terminal)
Run mode: Single Run, Sweeps and Corners
