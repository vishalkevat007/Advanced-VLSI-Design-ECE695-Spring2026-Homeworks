ADE simulation setup
Run mode: Single Run, Sweeps and Corners
Tests:
  AVD_HW1_function_tb_1: AVD_HW1/function_shanon_wrt_A_tb/schematic, simulator spectre
