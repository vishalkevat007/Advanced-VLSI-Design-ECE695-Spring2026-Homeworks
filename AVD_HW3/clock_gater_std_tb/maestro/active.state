ADE simulation setup
Test AVD_HW3_clock_gater_std_tb_1: AVD_HW3/clock_gater_std_tb/schematic, simulator spectre
  Models: /package/eda/cadence/gpdk045/gpdk045_v_6_0/gpdk045/../models/spectre/gpdk045.scs[tt]
  Temperature: 27
  Stimulus CLK: voltage pulse dc=1.1 val0=0 val1=1.1 period=1n rise=20p fall=20p width=500.0p srcType=pulse
  Stimulus EN: voltage pulse dc=1.1 val0=0 val1=1.1 period=8n delay=1.2n rise=20p fall=20p width=4n srcType=pulse
  Stimulus vdd!: voltage dc dc=1.1 srcType=dc
  Analysis tran: stop=10n
  Output Energy = integ((IT("/C0/PLUS") * VT("/CLK_G")) 0.0 1e-08 " ")
  Output Energy_Std = integ((IT("/I0/Vdd") * VT("/vdd!")) 2e-09 6e-09 nil)
  Signals: /CLK as CLK, /EN as EN, /I0/EN_L as EN_L, /CLK_G as CLK_G, /C0/PLUS (terminal), /I0/Vdd (terminal), /vdd!
Run mode: Single Run, Sweeps and Corners
