ADE simulation setup
Run mode: Single Run, Sweeps and Corners
Tests:
  AVD_HW2_ring_oscilator_13_tb_1: AVD_HW2/ring_oscilator_13_tb/schematic, simulator spectre
    Variables: VDD = 1.1
    Outputs: "/I0/n<12:0>"; frequency; timeperiod; n1_n2; Power
