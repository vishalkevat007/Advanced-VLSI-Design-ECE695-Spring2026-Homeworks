ADE simulation setup
Run mode: Single Run, Sweeps and Corners
Tests:
  Project_transmission_gate_tb_1: Project/transmission_gate_tb/schematic, simulator spectre
